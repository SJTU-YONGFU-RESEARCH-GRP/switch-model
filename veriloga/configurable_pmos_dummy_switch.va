// PMOS switch with dummy — symmetric half-width dummies for charge steering.

`include "configurable_switch.va"

module configurable_pmos_dummy_switch(in, out, clk, vdd, vss);

    inout in, out, clk, vdd, vss;
    electrical in, out, clk, vdd, vss;

    configurable_switch #(.SWITCH_KIND(6)) sw (
        .in(in), .out(out), .clk(clk), .clk_bar(clk), .vdd(vdd), .vss(vss)
    );

endmodule
