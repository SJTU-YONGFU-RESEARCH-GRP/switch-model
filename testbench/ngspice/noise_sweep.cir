* Channel noise at VCM — ngspice .noise (thermal) + .control flicker merge.
*
* Flicker 1/f density is computed inside ngspice control (no Python post-merge).
* Run via: python scripts/run_noise.py --simulator ngspice

.title switch_model_ngspice_noise_sweep

.param vclk_v=PLACEHOLDER_VCLK_V
.param vclk_bar_v=PLACEHOLDER_VCLK_BAR_V
.param vin_vcm_v=PLACEHOLDER_VIN_VCM_V
.param ron_ohm=PLACEHOLDER_RON_OHM

Vclk clk 0 DC {vclk_v}
Vclkb clkbar 0 DC {vclk_bar_v}
Vin in 0 DC {vin_vcm_v}
Vac vac 0 DC 0 AC 1

* Channel resistance at VCM bias (thermal noise from R).
Rsw in out {ron_ohm}
Rload out 0 1e12

.ac dec PLACEHOLDER_DEC PLACEHOLDER_FSTART PLACEHOLDER_FSTOP
.noise V(out) Vac dec PLACEHOLDER_DEC PLACEHOLDER_FSTART PLACEHOLDER_FSTOP
.control
run
setplot noise1
let flicker = PLACEHOLDER_FLICKER_EXPR
let total = sqrt(onoise_spectrum * onoise_spectrum + flicker * flicker)
wrdata noise_spectrum.raw frequency total
.endc

.end
