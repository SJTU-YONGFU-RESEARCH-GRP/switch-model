* Ron DC sweep — ngspice behavioral macromodel (same equations as Python / VA).
* Reference: Zhou et al., NEWCAS 2021.

.title switch_model_ngspice_ron_sweep

.param vclk_v=PLACEHOLDER_VCLK_V
.param vclk_bar_v=PLACEHOLDER_VCLK_BAR_V
.param vin_start_v=PLACEHOLDER_VIN_START_V
.param vin_stop_v=PLACEHOLDER_VIN_STOP_V
.param vin_step_v=PLACEHOLDER_VIN_STEP_V

Vclk clk 0 DC {vclk_v}
Vclkb clkbar 0 DC {vclk_bar_v}
Vin in 0 DC 0.9

* Probe outputs Ron(in) directly from macromodel equations.
Bprobe 0 probe V = { PLACEHOLDER_RON_PROBE_EXPR }

.dc Vin {vin_start_v} {vin_stop_v} {vin_step_v}
.control
run
set wr_singlescale
wrdata ron_sweep.raw v(in) v(probe)
.endc

.end
